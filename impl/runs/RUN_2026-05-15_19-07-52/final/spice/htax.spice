* NGSPICE file created from htax.ext - technology: sky130A

* Black-box entry subcircuit for sky130_fd_sc_hd__fill_1 abstract view
.subckt sky130_fd_sc_hd__fill_1 VGND VNB VPB VPWR
.ends

* Black-box entry subcircuit for sky130_fd_sc_hd__decap_3 abstract view
.subckt sky130_fd_sc_hd__decap_3 VGND VNB VPB VPWR
.ends

* Black-box entry subcircuit for sky130_fd_sc_hd__dfrtp_2 abstract view
.subckt sky130_fd_sc_hd__dfrtp_2 CLK D RESET_B VGND VNB VPB VPWR Q
.ends

* Black-box entry subcircuit for sky130_fd_sc_hd__mux2_1 abstract view
.subckt sky130_fd_sc_hd__mux2_1 A0 A1 S VGND VNB VPB VPWR X
.ends

* Black-box entry subcircuit for sky130_fd_sc_hd__fill_2 abstract view
.subckt sky130_fd_sc_hd__fill_2 VGND VNB VPB VPWR
.ends

* Black-box entry subcircuit for sky130_fd_sc_hd__clkbuf_4 abstract view
.subckt sky130_fd_sc_hd__clkbuf_4 A VGND VNB VPB VPWR X
.ends

* Black-box entry subcircuit for sky130_fd_sc_hd__dlygate4sd3_1 abstract view
.subckt sky130_fd_sc_hd__dlygate4sd3_1 A VGND VNB VPB VPWR X
.ends

* Black-box entry subcircuit for sky130_fd_sc_hd__clkdlybuf4s25_1 abstract view
.subckt sky130_fd_sc_hd__clkdlybuf4s25_1 A VGND VNB VPB VPWR X
.ends

* Black-box entry subcircuit for sky130_fd_sc_hd__clkbuf_16 abstract view
.subckt sky130_fd_sc_hd__clkbuf_16 A VGND VNB VPB VPWR X
.ends

* Black-box entry subcircuit for sky130_fd_sc_hd__tapvpwrvgnd_1 abstract view
.subckt sky130_fd_sc_hd__tapvpwrvgnd_1 VGND VPWR
.ends

* Black-box entry subcircuit for sky130_fd_sc_hd__buf_4 abstract view
.subckt sky130_fd_sc_hd__buf_4 A VGND VNB VPB VPWR X
.ends

* Black-box entry subcircuit for sky130_fd_sc_hd__clkbuf_2 abstract view
.subckt sky130_fd_sc_hd__clkbuf_2 A VGND VNB VPB VPWR X
.ends

* Black-box entry subcircuit for sky130_fd_sc_hd__o21a_2 abstract view
.subckt sky130_fd_sc_hd__o21a_2 A1 A2 B1 VGND VNB VPB VPWR X
.ends

* Black-box entry subcircuit for sky130_fd_sc_hd__xnor2_2 abstract view
.subckt sky130_fd_sc_hd__xnor2_2 A B VGND VNB VPB VPWR Y
.ends

* Black-box entry subcircuit for sky130_fd_sc_hd__xor2_2 abstract view
.subckt sky130_fd_sc_hd__xor2_2 A B VGND VNB VPB VPWR X
.ends

* Black-box entry subcircuit for sky130_fd_sc_hd__nand2b_2 abstract view
.subckt sky130_fd_sc_hd__nand2b_2 A_N B VGND VNB VPB VPWR Y
.ends

* Black-box entry subcircuit for sky130_fd_sc_hd__a21o_2 abstract view
.subckt sky130_fd_sc_hd__a21o_2 A1 A2 B1 VGND VNB VPB VPWR X
.ends

* Black-box entry subcircuit for sky130_fd_sc_hd__dfstp_2 abstract view
.subckt sky130_fd_sc_hd__dfstp_2 CLK D SET_B VGND VNB VPB VPWR Q
.ends

* Black-box entry subcircuit for sky130_fd_sc_hd__and2_2 abstract view
.subckt sky130_fd_sc_hd__and2_2 A B VGND VNB VPB VPWR X
.ends

* Black-box entry subcircuit for sky130_fd_sc_hd__and3_2 abstract view
.subckt sky130_fd_sc_hd__and3_2 A B C VGND VNB VPB VPWR X
.ends

* Black-box entry subcircuit for sky130_fd_sc_hd__or4_2 abstract view
.subckt sky130_fd_sc_hd__or4_2 A B C D VGND VNB VPB VPWR X
.ends

* Black-box entry subcircuit for sky130_fd_sc_hd__inv_2 abstract view
.subckt sky130_fd_sc_hd__inv_2 A VGND VNB VPB VPWR Y
.ends

* Black-box entry subcircuit for sky130_fd_sc_hd__a2bb2o_2 abstract view
.subckt sky130_fd_sc_hd__a2bb2o_2 A1_N A2_N B1 B2 VGND VNB VPB VPWR X
.ends

* Black-box entry subcircuit for sky130_fd_sc_hd__o21ba_2 abstract view
.subckt sky130_fd_sc_hd__o21ba_2 A1 A2 B1_N VGND VNB VPB VPWR X
.ends

* Black-box entry subcircuit for sky130_fd_sc_hd__nor2_2 abstract view
.subckt sky130_fd_sc_hd__nor2_2 A B VGND VNB VPB VPWR Y
.ends

.subckt htax VGND VPWR clk rst_n rx_data[0] rx_data[10] rx_data[11] rx_data[12] rx_data[13]
+ rx_data[14] rx_data[15] rx_data[16] rx_data[17] rx_data[18] rx_data[19] rx_data[1]
+ rx_data[20] rx_data[21] rx_data[22] rx_data[23] rx_data[24] rx_data[25] rx_data[26]
+ rx_data[27] rx_data[28] rx_data[29] rx_data[2] rx_data[30] rx_data[31] rx_data[3]
+ rx_data[4] rx_data[5] rx_data[6] rx_data[7] rx_data[8] rx_data[9] rx_valid tx_data[0]
+ tx_data[10] tx_data[11] tx_data[12] tx_data[13] tx_data[14] tx_data[15] tx_data[16]
+ tx_data[17] tx_data[18] tx_data[19] tx_data[1] tx_data[20] tx_data[21] tx_data[22]
+ tx_data[23] tx_data[24] tx_data[25] tx_data[26] tx_data[27] tx_data[28] tx_data[29]
+ tx_data[2] tx_data[30] tx_data[31] tx_data[3] tx_data[4] tx_data[5] tx_data[6] tx_data[7]
+ tx_data[8] tx_data[9] tx_ready tx_valid tx_vc[0] tx_vc[1] tx_vc[2]
XFILLER_22_111 VGND VGND VPWR VPWR sky130_fd_sc_hd__fill_1
XFILLER_13_111 VGND VGND VPWR VPWR sky130_fd_sc_hd__fill_1
XFILLER_3_67 VGND VGND VPWR VPWR sky130_fd_sc_hd__fill_1
XPHY_EDGE_ROW_0_Left_23 VGND VGND VPWR VPWR sky130_fd_sc_hd__decap_3
X_131_ _134_/CLK _131_/D load_slew74/X VGND VGND VPWR VPWR _131_/Q sky130_fd_sc_hd__dfrtp_2
X_062_ _062_/A0 _062_/A1 _146_/D VGND VGND VPWR VPWR _111_/D sky130_fd_sc_hd__mux2_1
XFILLER_0_57 VGND VGND VPWR VPWR sky130_fd_sc_hd__decap_3
XFILLER_17_9 VGND VGND VPWR VPWR sky130_fd_sc_hd__fill_1
XFILLER_2_132 VGND VGND VPWR VPWR sky130_fd_sc_hd__fill_2
X_114_ _133_/CLK _114_/D load_slew76/X VGND VGND VPWR VPWR _114_/Q sky130_fd_sc_hd__dfrtp_2
Xload_slew74 fanout73/X VGND VGND VPWR VPWR load_slew74/X sky130_fd_sc_hd__clkbuf_4
Xhold85 _131_/Q VGND VGND VPWR VPWR hold85/X sky130_fd_sc_hd__dlygate4sd3_1
Xhold96 _126_/Q VGND VGND VPWR VPWR hold96/X sky130_fd_sc_hd__dlygate4sd3_1
XFILLER_15_87 VGND VGND VPWR VPWR sky130_fd_sc_hd__decap_3
XFILLER_16_131 VGND VGND VPWR VPWR sky130_fd_sc_hd__decap_3
Xoutput42 _125_/Q VGND VGND VPWR VPWR rx_data[16] sky130_fd_sc_hd__clkdlybuf4s25_1
Xoutput53 _135_/Q VGND VGND VPWR VPWR rx_data[26] sky130_fd_sc_hd__clkdlybuf4s25_1
Xoutput64 _116_/Q VGND VGND VPWR VPWR rx_data[7] sky130_fd_sc_hd__clkdlybuf4s25_1
Xclkbuf_3_6__f_clk clkbuf_0_clk/X VGND VGND VPWR VPWR _145_/CLK sky130_fd_sc_hd__clkbuf_16
XFILLER_9_116 VGND VGND VPWR VPWR sky130_fd_sc_hd__fill_2
XFILLER_3_57 VGND VGND VPWR VPWR sky130_fd_sc_hd__fill_2
XFILLER_12_44 VGND VGND VPWR VPWR sky130_fd_sc_hd__decap_3
XFILLER_12_55 VGND VGND VPWR VPWR sky130_fd_sc_hd__decap_3
XFILLER_12_88 VGND VGND VPWR VPWR sky130_fd_sc_hd__decap_3
X_130_ _138_/CLK _130_/D load_slew76/X VGND VGND VPWR VPWR _130_/Q sky130_fd_sc_hd__dfrtp_2
XPHY_EDGE_ROW_21_Right_21 VGND VGND VPWR VPWR sky130_fd_sc_hd__decap_3
XPHY_EDGE_ROW_12_Right_12 VGND VGND VPWR VPWR sky130_fd_sc_hd__decap_3
X_061_ hold88/X _061_/A1 _146_/D VGND VGND VPWR VPWR _110_/D sky130_fd_sc_hd__mux2_1
X_113_ _133_/CLK _113_/D load_slew76/X VGND VGND VPWR VPWR _113_/Q sky130_fd_sc_hd__dfrtp_2
Xhold86 _123_/Q VGND VGND VPWR VPWR hold86/X sky130_fd_sc_hd__dlygate4sd3_1
Xhold97 _137_/Q VGND VGND VPWR VPWR hold97/X sky130_fd_sc_hd__dlygate4sd3_1
XTAP_TAPCELL_ROW_20_88 VGND VPWR sky130_fd_sc_hd__tapvpwrvgnd_1
XFILLER_6_24 VGND VGND VPWR VPWR sky130_fd_sc_hd__decap_3
XFILLER_15_66 VGND VGND VPWR VPWR sky130_fd_sc_hd__decap_3
XPHY_EDGE_ROW_6_Right_6 VGND VGND VPWR VPWR sky130_fd_sc_hd__decap_3
Xoutput43 _126_/Q VGND VGND VPWR VPWR rx_data[17] sky130_fd_sc_hd__clkdlybuf4s25_1
Xoutput54 _136_/Q VGND VGND VPWR VPWR rx_data[27] sky130_fd_sc_hd__clkdlybuf4s25_1
Xoutput65 _117_/Q VGND VGND VPWR VPWR rx_data[8] sky130_fd_sc_hd__clkdlybuf4s25_1
XFILLER_22_113 VGND VGND VPWR VPWR sky130_fd_sc_hd__decap_3
XFILLER_22_124 VGND VGND VPWR VPWR sky130_fd_sc_hd__fill_2
XFILLER_9_106 VGND VGND VPWR VPWR sky130_fd_sc_hd__decap_3
X_060_ hold89/X input2/X _088_/S VGND VGND VPWR VPWR _109_/D sky130_fd_sc_hd__mux2_1
XFILLER_3_3 VGND VGND VPWR VPWR sky130_fd_sc_hd__decap_3
XFILLER_18_88 VGND VGND VPWR VPWR sky130_fd_sc_hd__fill_1
X_112_ _134_/CLK _112_/D load_slew74/X VGND VGND VPWR VPWR _112_/Q sky130_fd_sc_hd__dfrtp_2
XTAP_TAPCELL_ROW_5_58 VGND VPWR sky130_fd_sc_hd__tapvpwrvgnd_1
Xload_slew76 fanout75/X VGND VGND VPWR VPWR load_slew76/X sky130_fd_sc_hd__buf_4
XFILLER_20_56 VGND VGND VPWR VPWR sky130_fd_sc_hd__fill_2
XTAP_TAPCELL_ROW_20_89 VGND VPWR sky130_fd_sc_hd__tapvpwrvgnd_1
Xhold87 _132_/Q VGND VGND VPWR VPWR hold87/X sky130_fd_sc_hd__dlygate4sd3_1
Xhold98 _135_/Q VGND VGND VPWR VPWR hold98/X sky130_fd_sc_hd__dlygate4sd3_1
XPHY_EDGE_ROW_16_Left_39 VGND VGND VPWR VPWR sky130_fd_sc_hd__decap_3
XTAP_TAPCELL_ROW_15_78 VGND VPWR sky130_fd_sc_hd__tapvpwrvgnd_1
XFILLER_15_78 VGND VGND VPWR VPWR sky130_fd_sc_hd__decap_3
Xoutput44 _127_/Q VGND VGND VPWR VPWR rx_data[18] sky130_fd_sc_hd__clkdlybuf4s25_1
Xoutput55 _137_/Q VGND VGND VPWR VPWR rx_data[28] sky130_fd_sc_hd__clkdlybuf4s25_1
Xoutput66 _118_/Q VGND VGND VPWR VPWR rx_data[9] sky130_fd_sc_hd__clkdlybuf4s25_1
XFILLER_3_37 VGND VGND VPWR VPWR sky130_fd_sc_hd__fill_2
XPHY_EDGE_ROW_19_Left_42 VGND VGND VPWR VPWR sky130_fd_sc_hd__decap_3
XPHY_EDGE_ROW_4_Left_27 VGND VGND VPWR VPWR sky130_fd_sc_hd__decap_3
X_111_ _138_/CLK _111_/D load_slew76/X VGND VGND VPWR VPWR _111_/Q sky130_fd_sc_hd__dfrtp_2
XTAP_TAPCELL_ROW_5_59 VGND VPWR sky130_fd_sc_hd__tapvpwrvgnd_1
XFILLER_20_79 VGND VGND VPWR VPWR sky130_fd_sc_hd__decap_3
Xhold88 _110_/Q VGND VGND VPWR VPWR hold88/X sky130_fd_sc_hd__dlygate4sd3_1
Xhold99 _118_/Q VGND VGND VPWR VPWR hold99/X sky130_fd_sc_hd__dlygate4sd3_1
XPHY_EDGE_ROW_7_Left_30 VGND VGND VPWR VPWR sky130_fd_sc_hd__decap_3
XTAP_TAPCELL_ROW_15_79 VGND VPWR sky130_fd_sc_hd__tapvpwrvgnd_1
XFILLER_15_57 VGND VGND VPWR VPWR sky130_fd_sc_hd__decap_3
Xoutput45 _128_/Q VGND VGND VPWR VPWR rx_data[19] sky130_fd_sc_hd__clkdlybuf4s25_1
Xoutput56 _138_/Q VGND VGND VPWR VPWR rx_data[29] sky130_fd_sc_hd__clkdlybuf4s25_1
Xoutput67 _141_/Q VGND VGND VPWR VPWR rx_valid sky130_fd_sc_hd__clkdlybuf4s25_1
XFILLER_11_3 VGND VGND VPWR VPWR sky130_fd_sc_hd__decap_3
XFILLER_7_80 VGND VGND VPWR VPWR sky130_fd_sc_hd__decap_3
XFILLER_12_58 VGND VGND VPWR VPWR sky130_fd_sc_hd__decap_3
XPHY_EDGE_ROW_20_Left_43 VGND VGND VPWR VPWR sky130_fd_sc_hd__decap_3
Xfanout80 input1/X VGND VGND VPWR VPWR fanout80/X sky130_fd_sc_hd__clkdlybuf4s25_1
XFILLER_18_57 VGND VGND VPWR VPWR sky130_fd_sc_hd__decap_3
XFILLER_18_79 VGND VGND VPWR VPWR sky130_fd_sc_hd__decap_3
Xload_slew78 fanout77/X VGND VGND VPWR VPWR _058_/B sky130_fd_sc_hd__clkbuf_2
Xclkload0 _140_/CLK VGND VGND VPWR VPWR clkload0/X sky130_fd_sc_hd__clkbuf_4
X_110_ _133_/CLK _110_/D fanout75/X VGND VGND VPWR VPWR _110_/Q sky130_fd_sc_hd__dfrtp_2
Xhold89 _109_/Q VGND VGND VPWR VPWR hold89/X sky130_fd_sc_hd__dlygate4sd3_1
XFILLER_6_27 VGND VGND VPWR VPWR sky130_fd_sc_hd__fill_1
XFILLER_15_36 VGND VGND VPWR VPWR sky130_fd_sc_hd__fill_2
XFILLER_15_47 VGND VGND VPWR VPWR sky130_fd_sc_hd__fill_1
XFILLER_15_69 VGND VGND VPWR VPWR sky130_fd_sc_hd__decap_3
Xoutput35 _109_/Q VGND VGND VPWR VPWR rx_data[0] sky130_fd_sc_hd__clkdlybuf4s25_1
Xoutput46 _110_/Q VGND VGND VPWR VPWR rx_data[1] sky130_fd_sc_hd__clkdlybuf4s25_1
Xoutput57 _111_/Q VGND VGND VPWR VPWR rx_data[2] sky130_fd_sc_hd__clkdlybuf4s25_1
Xoutput68 _059_/B VGND VGND VPWR VPWR tx_ready sky130_fd_sc_hd__clkdlybuf4s25_1
Xclkbuf_3_1__f_clk clkbuf_0_clk/X VGND VGND VPWR VPWR _134_/CLK sky130_fd_sc_hd__clkbuf_16
XTAP_TAPCELL_ROW_21_90 VGND VPWR sky130_fd_sc_hd__tapvpwrvgnd_1
XPHY_EDGE_ROW_19_Right_19 VGND VGND VPWR VPWR sky130_fd_sc_hd__decap_3
XFILLER_9_109 VGND VGND VPWR VPWR sky130_fd_sc_hd__decap_3
XFILLER_4_82 VGND VGND VPWR VPWR sky130_fd_sc_hd__fill_2
Xfanout70 _089_/S VGND VGND VPWR VPWR _146_/D sky130_fd_sc_hd__clkdlybuf4s25_1
XFILLER_9_49 VGND VGND VPWR VPWR sky130_fd_sc_hd__fill_1
XFILLER_9_27 VGND VGND VPWR VPWR sky130_fd_sc_hd__fill_1
XFILLER_9_16 VGND VGND VPWR VPWR sky130_fd_sc_hd__decap_3
XFILLER_3_6 VGND VGND VPWR VPWR sky130_fd_sc_hd__fill_1
XFILLER_18_69 VGND VGND VPWR VPWR sky130_fd_sc_hd__fill_2
XFILLER_1_3 VGND VGND VPWR VPWR sky130_fd_sc_hd__decap_3
Xclkload1 _134_/CLK VGND VGND VPWR VPWR clkload1/X sky130_fd_sc_hd__clkbuf_4
XTAP_TAPCELL_ROW_6_60 VGND VPWR sky130_fd_sc_hd__tapvpwrvgnd_1
Xoutput36 _119_/Q VGND VGND VPWR VPWR rx_data[10] sky130_fd_sc_hd__clkdlybuf4s25_1
Xoutput47 _129_/Q VGND VGND VPWR VPWR rx_data[20] sky130_fd_sc_hd__clkdlybuf4s25_1
Xoutput58 _139_/Q VGND VGND VPWR VPWR rx_data[30] sky130_fd_sc_hd__clkdlybuf4s25_1
XTAP_TAPCELL_ROW_21_91 VGND VPWR sky130_fd_sc_hd__tapvpwrvgnd_1
XTAP_TAPCELL_ROW_16_80 VGND VPWR sky130_fd_sc_hd__tapvpwrvgnd_1
XFILLER_16_91 VGND VGND VPWR VPWR sky130_fd_sc_hd__decap_3
XFILLER_8_110 VGND VGND VPWR VPWR sky130_fd_sc_hd__decap_3
XFILLER_12_27 VGND VGND VPWR VPWR sky130_fd_sc_hd__fill_1
Xhold110 _121_/Q VGND VGND VPWR VPWR _072_/A0 sky130_fd_sc_hd__dlygate4sd3_1
XFILLER_5_113 VGND VGND VPWR VPWR sky130_fd_sc_hd__decap_3
Xfanout71 _089_/S VGND VGND VPWR VPWR _090_/S sky130_fd_sc_hd__clkdlybuf4s25_1
XFILLER_18_37 VGND VGND VPWR VPWR sky130_fd_sc_hd__fill_2
XFILLER_18_48 VGND VGND VPWR VPWR sky130_fd_sc_hd__fill_1
Xclkload2 _139_/CLK VGND VGND VPWR VPWR clkload2/X sky130_fd_sc_hd__clkbuf_4
X_099_ _094_/A _097_/B _095_/Y VGND VGND VPWR VPWR _103_/A sky130_fd_sc_hd__o21a_2
XFILLER_20_27 VGND VGND VPWR VPWR sky130_fd_sc_hd__fill_1
XFILLER_19_91 VGND VGND VPWR VPWR sky130_fd_sc_hd__decap_3
XFILLER_6_29 VGND VGND VPWR VPWR sky130_fd_sc_hd__decap_3
XTAP_TAPCELL_ROW_6_61 VGND VPWR sky130_fd_sc_hd__tapvpwrvgnd_1
Xoutput37 _120_/Q VGND VGND VPWR VPWR rx_data[11] sky130_fd_sc_hd__clkdlybuf4s25_1
Xoutput48 _130_/Q VGND VGND VPWR VPWR rx_data[21] sky130_fd_sc_hd__clkdlybuf4s25_1
Xoutput59 _140_/Q VGND VGND VPWR VPWR rx_data[31] sky130_fd_sc_hd__clkdlybuf4s25_1
XPHY_EDGE_ROW_1_Right_1 VGND VGND VPWR VPWR sky130_fd_sc_hd__decap_3
XFILLER_11_6 VGND VGND VPWR VPWR sky130_fd_sc_hd__fill_1
XTAP_TAPCELL_ROW_16_81 VGND VPWR sky130_fd_sc_hd__tapvpwrvgnd_1
XFILLER_7_83 VGND VGND VPWR VPWR sky130_fd_sc_hd__fill_1
XFILLER_16_81 VGND VGND VPWR VPWR sky130_fd_sc_hd__decap_3
Xhold111 _116_/Q VGND VGND VPWR VPWR _067_/A0 sky130_fd_sc_hd__dlygate4sd3_1
Xhold100 _112_/Q VGND VGND VPWR VPWR _063_/A0 sky130_fd_sc_hd__dlygate4sd3_1
Xfanout72 _059_/X VGND VGND VPWR VPWR _089_/S sky130_fd_sc_hd__clkdlybuf4s25_1
Xclkbuf_3_7__f_clk clkbuf_0_clk/X VGND VGND VPWR VPWR _125_/CLK sky130_fd_sc_hd__clkbuf_16
XFILLER_18_16 VGND VGND VPWR VPWR sky130_fd_sc_hd__decap_3
Xclkload3 _146_/CLK VGND VGND VPWR VPWR clkload3/X sky130_fd_sc_hd__clkbuf_4
X_098_ _143_/Q _097_/Y _104_/S VGND VGND VPWR VPWR _143_/D sky130_fd_sc_hd__mux2_1
XFILLER_1_30 VGND VGND VPWR VPWR sky130_fd_sc_hd__decap_3
XPHY_EDGE_ROW_11_Left_34 VGND VGND VPWR VPWR sky130_fd_sc_hd__decap_3
Xoutput38 _121_/Q VGND VGND VPWR VPWR rx_data[12] sky130_fd_sc_hd__clkdlybuf4s25_1
Xoutput49 _131_/Q VGND VGND VPWR VPWR rx_data[22] sky130_fd_sc_hd__clkdlybuf4s25_1
XFILLER_21_60 VGND VGND VPWR VPWR sky130_fd_sc_hd__decap_3
Xclkbuf_0_clk clk VGND VGND VPWR VPWR clkbuf_0_clk/X sky130_fd_sc_hd__clkbuf_16
XFILLER_13_108 VGND VGND VPWR VPWR sky130_fd_sc_hd__decap_3
XPHY_EDGE_ROW_15_Right_15 VGND VGND VPWR VPWR sky130_fd_sc_hd__decap_3
Xhold112 _138_/Q VGND VGND VPWR VPWR _089_/A0 sky130_fd_sc_hd__dlygate4sd3_1
Xhold101 _127_/Q VGND VGND VPWR VPWR _078_/A0 sky130_fd_sc_hd__dlygate4sd3_1
XFILLER_4_85 VGND VGND VPWR VPWR sky130_fd_sc_hd__fill_1
XFILLER_2_118 VGND VGND VPWR VPWR sky130_fd_sc_hd__fill_1
Xfanout73 fanout80/X VGND VGND VPWR VPWR fanout73/X sky130_fd_sc_hd__clkdlybuf4s25_1
XFILLER_1_6 VGND VGND VPWR VPWR sky130_fd_sc_hd__fill_1
Xclkload4 _133_/CLK VGND VGND VPWR VPWR clkload4/X sky130_fd_sc_hd__clkbuf_4
X_097_ _142_/Q _097_/B VGND VGND VPWR VPWR _097_/Y sky130_fd_sc_hd__xnor2_2
XFILLER_19_60 VGND VGND VPWR VPWR sky130_fd_sc_hd__fill_2
Xoutput39 _122_/Q VGND VGND VPWR VPWR rx_data[13] sky130_fd_sc_hd__clkdlybuf4s25_1
XFILLER_16_128 VGND VGND VPWR VPWR sky130_fd_sc_hd__decap_3
XFILLER_16_72 VGND VGND VPWR VPWR sky130_fd_sc_hd__decap_3
XFILLER_16_94 VGND VGND VPWR VPWR sky130_fd_sc_hd__decap_3
XFILLER_21_131 VGND VGND VPWR VPWR sky130_fd_sc_hd__decap_3
Xhold113 _115_/Q VGND VGND VPWR VPWR _066_/A0 sky130_fd_sc_hd__dlygate4sd3_1
Xhold102 _130_/Q VGND VGND VPWR VPWR _081_/A0 sky130_fd_sc_hd__dlygate4sd3_1
XFILLER_5_116 VGND VGND VPWR VPWR sky130_fd_sc_hd__fill_2
Xclkload5 _138_/CLK VGND VGND VPWR VPWR clkload5/X sky130_fd_sc_hd__clkbuf_4
XFILLER_1_76 VGND VGND VPWR VPWR sky130_fd_sc_hd__fill_2
X_096_ _146_/Q _143_/Q VGND VGND VPWR VPWR _097_/B sky130_fd_sc_hd__xor2_2
XFILLER_10_85 VGND VGND VPWR VPWR sky130_fd_sc_hd__decap_3
XFILLER_19_94 VGND VGND VPWR VPWR sky130_fd_sc_hd__fill_1
X_079_ hold92/X _079_/A1 _146_/D VGND VGND VPWR VPWR _128_/D sky130_fd_sc_hd__mux2_1
XFILLER_21_73 VGND VGND VPWR VPWR sky130_fd_sc_hd__fill_2
XFILLER_21_84 VGND VGND VPWR VPWR sky130_fd_sc_hd__decap_3
XPHY_EDGE_ROW_5_Right_5 VGND VGND VPWR VPWR sky130_fd_sc_hd__decap_3
XTAP_TAPCELL_ROW_3_54 VGND VPWR sky130_fd_sc_hd__tapvpwrvgnd_1
Xhold114 _144_/Q VGND VGND VPWR VPWR _104_/A0 sky130_fd_sc_hd__dlygate4sd3_1
Xhold103 _119_/Q VGND VGND VPWR VPWR _070_/A0 sky130_fd_sc_hd__dlygate4sd3_1
XFILLER_13_63 VGND VGND VPWR VPWR sky130_fd_sc_hd__fill_2
XFILLER_1_131 VGND VGND VPWR VPWR sky130_fd_sc_hd__decap_3
Xfanout75 fanout80/X VGND VGND VPWR VPWR fanout75/X sky130_fd_sc_hd__clkdlybuf4s25_1
XTAP_TAPCELL_ROW_13_74 VGND VPWR sky130_fd_sc_hd__tapvpwrvgnd_1
XFILLER_18_19 VGND VGND VPWR VPWR sky130_fd_sc_hd__fill_1
Xclkload6 _125_/CLK VGND VGND VPWR VPWR clkload6/X sky130_fd_sc_hd__clkbuf_4
XFILLER_1_33 VGND VGND VPWR VPWR sky130_fd_sc_hd__fill_2
XFILLER_1_99 VGND VGND VPWR VPWR sky130_fd_sc_hd__decap_3
X_095_ _146_/Q _143_/Q VGND VGND VPWR VPWR _095_/Y sky130_fd_sc_hd__nand2b_2
XFILLER_18_3 VGND VGND VPWR VPWR sky130_fd_sc_hd__decap_3
X_078_ _078_/A0 _078_/A1 _146_/D VGND VGND VPWR VPWR _127_/D sky130_fd_sc_hd__mux2_1
XFILLER_21_63 VGND VGND VPWR VPWR sky130_fd_sc_hd__fill_1
XPHY_EDGE_ROW_15_Left_38 VGND VGND VPWR VPWR sky130_fd_sc_hd__decap_3
XFILLER_21_111 VGND VGND VPWR VPWR sky130_fd_sc_hd__fill_1
XFILLER_16_85 VGND VGND VPWR VPWR sky130_fd_sc_hd__decap_3
XTAP_TAPCELL_ROW_3_55 VGND VPWR sky130_fd_sc_hd__tapvpwrvgnd_1
XPHY_EDGE_ROW_20_Right_20 VGND VGND VPWR VPWR sky130_fd_sc_hd__decap_3
XPHY_EDGE_ROW_11_Right_11 VGND VGND VPWR VPWR sky130_fd_sc_hd__decap_3
Xhold104 _134_/Q VGND VGND VPWR VPWR _085_/A0 sky130_fd_sc_hd__dlygate4sd3_1
Xclkbuf_3_2__f_clk clkbuf_0_clk/X VGND VGND VPWR VPWR _139_/CLK sky130_fd_sc_hd__clkbuf_16
XTAP_TAPCELL_ROW_13_75 VGND VPWR sky130_fd_sc_hd__tapvpwrvgnd_1
XPHY_EDGE_ROW_18_Left_41 VGND VGND VPWR VPWR sky130_fd_sc_hd__decap_3
XPHY_EDGE_ROW_3_Left_26 VGND VGND VPWR VPWR sky130_fd_sc_hd__decap_3
X_094_ _094_/A _104_/S VGND VGND VPWR VPWR _142_/D sky130_fd_sc_hd__xnor2_2
XFILLER_10_65 VGND VGND VPWR VPWR sky130_fd_sc_hd__decap_3
XFILLER_19_30 VGND VGND VPWR VPWR sky130_fd_sc_hd__decap_3
X_146_ _146_/CLK _146_/D _058_/B VGND VGND VPWR VPWR _146_/Q sky130_fd_sc_hd__dfrtp_2
X_077_ hold96/X _077_/A1 _088_/S VGND VGND VPWR VPWR _126_/D sky130_fd_sc_hd__mux2_1
X_129_ _139_/CLK _129_/D fanout77/X VGND VGND VPWR VPWR _129_/Q sky130_fd_sc_hd__dfrtp_2
XFILLER_16_75 VGND VGND VPWR VPWR sky130_fd_sc_hd__decap_3
XFILLER_16_97 VGND VGND VPWR VPWR sky130_fd_sc_hd__decap_3
Xhold105 _120_/Q VGND VGND VPWR VPWR _071_/A0 sky130_fd_sc_hd__dlygate4sd3_1
XFILLER_1_111 VGND VGND VPWR VPWR sky130_fd_sc_hd__fill_1
Xfanout77 fanout80/X VGND VGND VPWR VPWR fanout77/X sky130_fd_sc_hd__clkdlybuf4s25_1
XTAP_TAPCELL_ROW_9_66 VGND VPWR sky130_fd_sc_hd__tapvpwrvgnd_1
XTAP_TAPCELL_ROW_0_46 VGND VPWR sky130_fd_sc_hd__tapvpwrvgnd_1
XFILLER_8_3 VGND VGND VPWR VPWR sky130_fd_sc_hd__decap_3
X_093_ _146_/Q _056_/Y _089_/S VGND VGND VPWR VPWR _104_/S sky130_fd_sc_hd__a21o_2
XFILLER_1_57 VGND VGND VPWR VPWR sky130_fd_sc_hd__fill_2
XFILLER_10_88 VGND VGND VPWR VPWR sky130_fd_sc_hd__fill_2
Xinput1 rst_n VGND VGND VPWR VPWR input1/X sky130_fd_sc_hd__clkdlybuf4s25_1
XTAP_TAPCELL_ROW_19_86 VGND VPWR sky130_fd_sc_hd__tapvpwrvgnd_1
X_145_ _145_/CLK _145_/D fanout79/X VGND VGND VPWR VPWR _145_/Q sky130_fd_sc_hd__dfstp_2
X_076_ _076_/A0 input9/X _090_/S VGND VGND VPWR VPWR _125_/D sky130_fd_sc_hd__mux2_1
XFILLER_15_132 VGND VGND VPWR VPWR sky130_fd_sc_hd__fill_2
XFILLER_21_87 VGND VGND VPWR VPWR sky130_fd_sc_hd__fill_1
XFILLER_21_113 VGND VGND VPWR VPWR sky130_fd_sc_hd__decap_3
X_128_ _133_/CLK _128_/D load_slew76/X VGND VGND VPWR VPWR _128_/Q sky130_fd_sc_hd__dfrtp_2
X_059_ _059_/A _059_/B VGND VGND VPWR VPWR _059_/X sky130_fd_sc_hd__and2_2
XFILLER_7_34 VGND VGND VPWR VPWR sky130_fd_sc_hd__fill_1
Xhold106 _125_/Q VGND VGND VPWR VPWR _076_/A0 sky130_fd_sc_hd__dlygate4sd3_1
XPHY_EDGE_ROW_9_Right_9 VGND VGND VPWR VPWR sky130_fd_sc_hd__decap_3
XFILLER_4_79 VGND VGND VPWR VPWR sky130_fd_sc_hd__decap_3
XFILLER_13_11 VGND VGND VPWR VPWR sky130_fd_sc_hd__decap_3
XFILLER_13_55 VGND VGND VPWR VPWR sky130_fd_sc_hd__fill_1
XTAP_TAPCELL_ROW_9_67 VGND VPWR sky130_fd_sc_hd__tapvpwrvgnd_1
XTAP_TAPCELL_ROW_0_47 VGND VPWR sky130_fd_sc_hd__tapvpwrvgnd_1
X_092_ _101_/A hold81/X _089_/S VGND VGND VPWR VPWR _141_/D sky130_fd_sc_hd__a21o_2
Xinput2 tx_data[0] VGND VGND VPWR VPWR input2/X sky130_fd_sc_hd__clkdlybuf4s25_1
XTAP_TAPCELL_ROW_19_87 VGND VPWR sky130_fd_sc_hd__tapvpwrvgnd_1
X_144_ _145_/CLK _144_/D fanout79/X VGND VGND VPWR VPWR _144_/Q sky130_fd_sc_hd__dfrtp_2
X_075_ hold94/X input8/X _090_/S VGND VGND VPWR VPWR _124_/D sky130_fd_sc_hd__mux2_1
XFILLER_18_6 VGND VGND VPWR VPWR sky130_fd_sc_hd__fill_1
XFILLER_15_111 VGND VGND VPWR VPWR sky130_fd_sc_hd__fill_1
XFILLER_16_3 VGND VGND VPWR VPWR sky130_fd_sc_hd__decap_3
X_127_ _138_/CLK _127_/D load_slew76/X VGND VGND VPWR VPWR _127_/Q sky130_fd_sc_hd__dfrtp_2
X_058_ _101_/A _058_/B _058_/C VGND VGND VPWR VPWR _059_/B sky130_fd_sc_hd__and3_2
XFILLER_7_57 VGND VGND VPWR VPWR sky130_fd_sc_hd__fill_1
XFILLER_16_88 VGND VGND VPWR VPWR sky130_fd_sc_hd__decap_3
Xhold107 _111_/Q VGND VGND VPWR VPWR _062_/A0 sky130_fd_sc_hd__dlygate4sd3_1
XFILLER_1_113 VGND VGND VPWR VPWR sky130_fd_sc_hd__decap_3
Xfanout79 fanout80/X VGND VGND VPWR VPWR fanout79/X sky130_fd_sc_hd__clkdlybuf4s25_1
XTAP_TAPCELL_ROW_0_48 VGND VPWR sky130_fd_sc_hd__tapvpwrvgnd_1
X_091_ hold83/X _091_/A1 _146_/D VGND VGND VPWR VPWR _140_/D sky130_fd_sc_hd__mux2_1
Xinput3 tx_data[10] VGND VGND VPWR VPWR input3/X sky130_fd_sc_hd__clkdlybuf4s25_1
XTAP_TAPCELL_ROW_10_68 VGND VPWR sky130_fd_sc_hd__tapvpwrvgnd_1
XPHY_EDGE_ROW_18_Right_18 VGND VGND VPWR VPWR sky130_fd_sc_hd__decap_3
XFILLER_10_68 VGND VGND VPWR VPWR sky130_fd_sc_hd__decap_3
XFILLER_19_33 VGND VGND VPWR VPWR sky130_fd_sc_hd__fill_1
XFILLER_19_55 VGND VGND VPWR VPWR sky130_fd_sc_hd__fill_1
X_143_ _146_/CLK _143_/D _058_/B VGND VGND VPWR VPWR _143_/Q sky130_fd_sc_hd__dfrtp_2
X_074_ hold86/X input7/X _090_/S VGND VGND VPWR VPWR _123_/D sky130_fd_sc_hd__mux2_1
X_126_ _140_/CLK _126_/D load_slew74/X VGND VGND VPWR VPWR _126_/Q sky130_fd_sc_hd__dfrtp_2
X_057_ _142_/Q _143_/Q _144_/Q _145_/Q VGND VGND VPWR VPWR _058_/C sky130_fd_sc_hd__or4_2
XFILLER_16_78 VGND VGND VPWR VPWR sky130_fd_sc_hd__decap_3
XPHY_EDGE_ROW_0_Right_0 VGND VGND VPWR VPWR sky130_fd_sc_hd__decap_3
Xhold108 _136_/Q VGND VGND VPWR VPWR _087_/A0 sky130_fd_sc_hd__dlygate4sd3_1
X_109_ _134_/CLK _109_/D load_slew74/X VGND VGND VPWR VPWR _109_/Q sky130_fd_sc_hd__dfrtp_2
XFILLER_4_37 VGND VGND VPWR VPWR sky130_fd_sc_hd__fill_2
Xfanout69 _146_/D VGND VGND VPWR VPWR _088_/S sky130_fd_sc_hd__clkdlybuf4s25_1
XTAP_TAPCELL_ROW_0_49 VGND VPWR sky130_fd_sc_hd__tapvpwrvgnd_1
XFILLER_5_91 VGND VGND VPWR VPWR sky130_fd_sc_hd__decap_3
XFILLER_1_16 VGND VGND VPWR VPWR sky130_fd_sc_hd__decap_3
X_090_ hold93/X _090_/A1 _090_/S VGND VGND VPWR VPWR _139_/D sky130_fd_sc_hd__mux2_1
XFILLER_6_3 VGND VGND VPWR VPWR sky130_fd_sc_hd__decap_3
Xinput4 tx_data[11] VGND VGND VPWR VPWR input4/X sky130_fd_sc_hd__clkdlybuf4s25_1
XTAP_TAPCELL_ROW_10_69 VGND VPWR sky130_fd_sc_hd__tapvpwrvgnd_1
X_142_ _146_/CLK _142_/D _058_/B VGND VGND VPWR VPWR _142_/Q sky130_fd_sc_hd__dfrtp_2
X_073_ hold91/X input6/X _090_/S VGND VGND VPWR VPWR _122_/D sky130_fd_sc_hd__mux2_1
XFILLER_21_57 VGND VGND VPWR VPWR sky130_fd_sc_hd__decap_3
X_125_ _125_/CLK _125_/D fanout79/X VGND VGND VPWR VPWR _125_/Q sky130_fd_sc_hd__dfrtp_2
X_056_ _145_/Q VGND VGND VPWR VPWR _056_/Y sky130_fd_sc_hd__inv_2
XFILLER_21_105 VGND VGND VPWR VPWR sky130_fd_sc_hd__decap_3
XFILLER_21_116 VGND VGND VPWR VPWR sky130_fd_sc_hd__decap_3
XPHY_EDGE_ROW_10_Left_33 VGND VGND VPWR VPWR sky130_fd_sc_hd__decap_3
XFILLER_16_24 VGND VGND VPWR VPWR sky130_fd_sc_hd__decap_3
XFILLER_21_3 VGND VGND VPWR VPWR sky130_fd_sc_hd__decap_3
Xhold109 _133_/Q VGND VGND VPWR VPWR _084_/A0 sky130_fd_sc_hd__dlygate4sd3_1
X_108_ _056_/Y _089_/S _104_/S _107_/Y VGND VGND VPWR VPWR _145_/D sky130_fd_sc_hd__a2bb2o_2
XFILLER_4_27 VGND VGND VPWR VPWR sky130_fd_sc_hd__fill_1
XFILLER_4_112 VGND VGND VPWR VPWR sky130_fd_sc_hd__fill_1
Xinput5 tx_data[12] VGND VGND VPWR VPWR input5/X sky130_fd_sc_hd__clkdlybuf4s25_1
XFILLER_19_57 VGND VGND VPWR VPWR sky130_fd_sc_hd__decap_3
X_141_ _145_/CLK _141_/D fanout79/X VGND VGND VPWR VPWR _141_/Q sky130_fd_sc_hd__dfrtp_2
X_072_ _072_/A0 input5/X _088_/S VGND VGND VPWR VPWR _121_/D sky130_fd_sc_hd__mux2_1
XFILLER_21_47 VGND VGND VPWR VPWR sky130_fd_sc_hd__fill_1
X_124_ _125_/CLK _124_/D fanout79/X VGND VGND VPWR VPWR _124_/Q sky130_fd_sc_hd__dfrtp_2
X_055_ _146_/Q VGND VGND VPWR VPWR _101_/A sky130_fd_sc_hd__inv_2
XFILLER_16_6 VGND VGND VPWR VPWR sky130_fd_sc_hd__fill_1
XFILLER_21_128 VGND VGND VPWR VPWR sky130_fd_sc_hd__decap_3
Xinput30 tx_data[6] VGND VGND VPWR VPWR _066_/A1 sky130_fd_sc_hd__clkdlybuf4s25_1
XFILLER_16_69 VGND VGND VPWR VPWR sky130_fd_sc_hd__decap_3
XFILLER_14_3 VGND VGND VPWR VPWR sky130_fd_sc_hd__decap_3
X_107_ _107_/A _107_/B VGND VGND VPWR VPWR _107_/Y sky130_fd_sc_hd__xnor2_2
XFILLER_1_116 VGND VGND VPWR VPWR sky130_fd_sc_hd__decap_3
XTAP_TAPCELL_ROW_1_50 VGND VPWR sky130_fd_sc_hd__tapvpwrvgnd_1
XFILLER_10_27 VGND VGND VPWR VPWR sky130_fd_sc_hd__fill_1
Xinput6 tx_data[13] VGND VGND VPWR VPWR input6/X sky130_fd_sc_hd__clkdlybuf4s25_1
Xclkbuf_3_3__f_clk clkbuf_0_clk/X VGND VGND VPWR VPWR _146_/CLK sky130_fd_sc_hd__clkbuf_16
X_140_ _140_/CLK _140_/D fanout80/X VGND VGND VPWR VPWR _140_/Q sky130_fd_sc_hd__dfrtp_2
X_071_ _071_/A0 input4/X _090_/S VGND VGND VPWR VPWR _120_/D sky130_fd_sc_hd__mux2_1
XPHY_EDGE_ROW_14_Right_14 VGND VGND VPWR VPWR sky130_fd_sc_hd__decap_3
XFILLER_2_94 VGND VGND VPWR VPWR sky130_fd_sc_hd__decap_3
XTAP_TAPCELL_ROW_11_70 VGND VPWR sky130_fd_sc_hd__tapvpwrvgnd_1
XFILLER_11_92 VGND VGND VPWR VPWR sky130_fd_sc_hd__decap_3
Xinput20 tx_data[26] VGND VGND VPWR VPWR _086_/A1 sky130_fd_sc_hd__clkdlybuf4s25_1
Xinput31 tx_data[7] VGND VGND VPWR VPWR _067_/A1 sky130_fd_sc_hd__clkdlybuf4s25_1
X_123_ _145_/CLK _123_/D fanout79/X VGND VGND VPWR VPWR _123_/Q sky130_fd_sc_hd__dfrtp_2
X_054_ _142_/Q VGND VGND VPWR VPWR _094_/A sky130_fd_sc_hd__inv_2
X_106_ _103_/A _102_/B _102_/A VGND VGND VPWR VPWR _107_/B sky130_fd_sc_hd__o21ba_2
XPHY_EDGE_ROW_4_Right_4 VGND VGND VPWR VPWR sky130_fd_sc_hd__decap_3
XFILLER_1_128 VGND VGND VPWR VPWR sky130_fd_sc_hd__decap_3
XFILLER_5_94 VGND VGND VPWR VPWR sky130_fd_sc_hd__fill_2
XFILLER_14_70 VGND VGND VPWR VPWR sky130_fd_sc_hd__decap_3
XFILLER_1_19 VGND VGND VPWR VPWR sky130_fd_sc_hd__fill_2
XFILLER_6_6 VGND VGND VPWR VPWR sky130_fd_sc_hd__fill_1
Xinput7 tx_data[14] VGND VGND VPWR VPWR input7/X sky130_fd_sc_hd__clkdlybuf4s25_1
XTAP_TAPCELL_ROW_1_51 VGND VPWR sky130_fd_sc_hd__tapvpwrvgnd_1
X_070_ _070_/A0 input3/X _088_/S VGND VGND VPWR VPWR _119_/D sky130_fd_sc_hd__mux2_1
XFILLER_4_3 VGND VGND VPWR VPWR sky130_fd_sc_hd__decap_3
XFILLER_15_105 VGND VGND VPWR VPWR sky130_fd_sc_hd__decap_3
XFILLER_21_16 VGND VGND VPWR VPWR sky130_fd_sc_hd__decap_3
XTAP_TAPCELL_ROW_11_71 VGND VPWR sky130_fd_sc_hd__tapvpwrvgnd_1
XFILLER_21_108 VGND VGND VPWR VPWR sky130_fd_sc_hd__decap_3
X_122_ _125_/CLK _122_/D load_slew76/X VGND VGND VPWR VPWR _122_/Q sky130_fd_sc_hd__dfrtp_2
XFILLER_16_27 VGND VGND VPWR VPWR sky130_fd_sc_hd__fill_1
XFILLER_20_130 VGND VGND VPWR VPWR sky130_fd_sc_hd__decap_3
Xinput10 tx_data[17] VGND VGND VPWR VPWR _077_/A1 sky130_fd_sc_hd__clkdlybuf4s25_1
Xinput21 tx_data[27] VGND VGND VPWR VPWR _087_/A1 sky130_fd_sc_hd__clkdlybuf4s25_1
Xinput32 tx_data[8] VGND VGND VPWR VPWR _068_/A1 sky130_fd_sc_hd__clkdlybuf4s25_1
X_105_ _146_/Q _145_/Q VGND VGND VPWR VPWR _107_/A sky130_fd_sc_hd__xnor2_2
XTAP_TAPCELL_ROW_22_92 VGND VPWR sky130_fd_sc_hd__tapvpwrvgnd_1
XFILLER_21_6 VGND VGND VPWR VPWR sky130_fd_sc_hd__fill_1
XPHY_EDGE_ROW_14_Left_37 VGND VGND VPWR VPWR sky130_fd_sc_hd__decap_3
XFILLER_8_83 VGND VGND VPWR VPWR sky130_fd_sc_hd__fill_1
XFILLER_17_81 VGND VGND VPWR VPWR sky130_fd_sc_hd__decap_3
XPHY_EDGE_ROW_17_Left_40 VGND VGND VPWR VPWR sky130_fd_sc_hd__decap_3
XFILLER_14_82 VGND VGND VPWR VPWR sky130_fd_sc_hd__fill_2
Xinput8 tx_data[15] VGND VGND VPWR VPWR input8/X sky130_fd_sc_hd__clkdlybuf4s25_1
XFILLER_19_27 VGND VGND VPWR VPWR sky130_fd_sc_hd__decap_3
XPHY_EDGE_ROW_2_Left_25 VGND VGND VPWR VPWR sky130_fd_sc_hd__decap_3
X_121_ _140_/CLK _121_/D load_slew74/X VGND VGND VPWR VPWR _121_/Q sky130_fd_sc_hd__dfrtp_2
Xinput11 tx_data[18] VGND VGND VPWR VPWR _078_/A1 sky130_fd_sc_hd__clkdlybuf4s25_1
Xinput22 tx_data[28] VGND VGND VPWR VPWR _088_/A1 sky130_fd_sc_hd__clkdlybuf4s25_1
Xinput33 tx_data[9] VGND VGND VPWR VPWR _069_/A1 sky130_fd_sc_hd__clkdlybuf4s25_1
XTAP_TAPCELL_ROW_7_62 VGND VPWR sky130_fd_sc_hd__tapvpwrvgnd_1
XFILLER_12_109 VGND VGND VPWR VPWR sky130_fd_sc_hd__fill_2
XTAP_TAPCELL_ROW_22_93 VGND VPWR sky130_fd_sc_hd__tapvpwrvgnd_1
X_104_ _104_/A0 _103_/Y _104_/S VGND VGND VPWR VPWR _144_/D sky130_fd_sc_hd__mux2_1
XTAP_TAPCELL_ROW_17_82 VGND VPWR sky130_fd_sc_hd__tapvpwrvgnd_1
XFILLER_12_3 VGND VGND VPWR VPWR sky130_fd_sc_hd__decap_3
XFILLER_14_61 VGND VGND VPWR VPWR sky130_fd_sc_hd__decap_3
Xinput9 tx_data[16] VGND VGND VPWR VPWR input9/X sky130_fd_sc_hd__clkdlybuf4s25_1
XPHY_EDGE_ROW_10_Right_10 VGND VGND VPWR VPWR sky130_fd_sc_hd__decap_3
XFILLER_11_95 VGND VGND VPWR VPWR sky130_fd_sc_hd__decap_3
XFILLER_15_129 VGND VGND VPWR VPWR sky130_fd_sc_hd__decap_3
X_120_ _139_/CLK _120_/D fanout77/X VGND VGND VPWR VPWR _120_/Q sky130_fd_sc_hd__dfrtp_2
Xinput12 tx_data[19] VGND VGND VPWR VPWR _079_/A1 sky130_fd_sc_hd__clkdlybuf4s25_1
Xinput23 tx_data[29] VGND VGND VPWR VPWR _089_/A1 sky130_fd_sc_hd__clkdlybuf4s25_1
Xinput34 tx_valid VGND VGND VPWR VPWR _059_/A sky130_fd_sc_hd__clkdlybuf4s25_1
XTAP_TAPCELL_ROW_7_63 VGND VPWR sky130_fd_sc_hd__tapvpwrvgnd_1
XTAP_TAPCELL_ROW_22_94 VGND VPWR sky130_fd_sc_hd__tapvpwrvgnd_1
XFILLER_11_110 VGND VGND VPWR VPWR sky130_fd_sc_hd__fill_2
XFILLER_22_50 VGND VGND VPWR VPWR sky130_fd_sc_hd__decap_3
X_103_ _103_/A _103_/B VGND VGND VPWR VPWR _103_/Y sky130_fd_sc_hd__xnor2_2
XFILLER_8_85 VGND VGND VPWR VPWR sky130_fd_sc_hd__decap_3
XFILLER_8_52 VGND VGND VPWR VPWR sky130_fd_sc_hd__fill_1
XTAP_TAPCELL_ROW_17_83 VGND VPWR sky130_fd_sc_hd__tapvpwrvgnd_1
XPHY_EDGE_ROW_8_Right_8 VGND VGND VPWR VPWR sky130_fd_sc_hd__decap_3
XFILLER_14_73 VGND VGND VPWR VPWR sky130_fd_sc_hd__decap_3
XFILLER_2_32 VGND VGND VPWR VPWR sky130_fd_sc_hd__fill_2
XFILLER_15_108 VGND VGND VPWR VPWR sky130_fd_sc_hd__decap_3
Xinput13 tx_data[1] VGND VGND VPWR VPWR _061_/A1 sky130_fd_sc_hd__clkdlybuf4s25_1
Xinput24 tx_data[2] VGND VGND VPWR VPWR _062_/A1 sky130_fd_sc_hd__clkdlybuf4s25_1
XFILLER_20_133 VGND VGND VPWR VPWR sky130_fd_sc_hd__fill_1
X_102_ _102_/A _102_/B VGND VGND VPWR VPWR _103_/B sky130_fd_sc_hd__nor2_2
XTAP_TAPCELL_ROW_22_95 VGND VPWR sky130_fd_sc_hd__tapvpwrvgnd_1
XFILLER_17_84 VGND VGND VPWR VPWR sky130_fd_sc_hd__decap_3
XFILLER_0_132 VGND VGND VPWR VPWR sky130_fd_sc_hd__fill_2
XFILLER_14_85 VGND VGND VPWR VPWR sky130_fd_sc_hd__decap_3
XPHY_EDGE_ROW_6_Left_29 VGND VGND VPWR VPWR sky130_fd_sc_hd__decap_3
XFILLER_11_86 VGND VGND VPWR VPWR sky130_fd_sc_hd__decap_3
Xinput14 tx_data[20] VGND VGND VPWR VPWR _080_/A1 sky130_fd_sc_hd__clkdlybuf4s25_1
Xinput25 tx_data[30] VGND VGND VPWR VPWR _090_/A1 sky130_fd_sc_hd__clkdlybuf4s25_1
XFILLER_11_101 VGND VGND VPWR VPWR sky130_fd_sc_hd__fill_2
X_101_ _101_/A _144_/Q VGND VGND VPWR VPWR _102_/B sky130_fd_sc_hd__nor2_2
XFILLER_7_116 VGND VGND VPWR VPWR sky130_fd_sc_hd__fill_2
XPHY_EDGE_ROW_9_Left_32 VGND VGND VPWR VPWR sky130_fd_sc_hd__decap_3
XFILLER_10_3 VGND VGND VPWR VPWR sky130_fd_sc_hd__decap_3
XFILLER_14_64 VGND VGND VPWR VPWR sky130_fd_sc_hd__decap_3
XPHY_EDGE_ROW_22_Left_45 VGND VGND VPWR VPWR sky130_fd_sc_hd__decap_3
XFILLER_11_43 VGND VGND VPWR VPWR sky130_fd_sc_hd__decap_3
XFILLER_14_132 VGND VGND VPWR VPWR sky130_fd_sc_hd__fill_2
Xinput15 tx_data[21] VGND VGND VPWR VPWR _081_/A1 sky130_fd_sc_hd__clkdlybuf4s25_1
Xinput26 tx_data[31] VGND VGND VPWR VPWR _091_/A1 sky130_fd_sc_hd__clkdlybuf4s25_1
XFILLER_11_113 VGND VGND VPWR VPWR sky130_fd_sc_hd__decap_3
XFILLER_11_124 VGND VGND VPWR VPWR sky130_fd_sc_hd__fill_2
XFILLER_22_53 VGND VGND VPWR VPWR sky130_fd_sc_hd__decap_3
X_100_ _101_/A _144_/Q VGND VGND VPWR VPWR _102_/A sky130_fd_sc_hd__and2_2
Xclkbuf_3_4__f_clk clkbuf_0_clk/X VGND VGND VPWR VPWR _133_/CLK sky130_fd_sc_hd__clkbuf_16
XFILLER_8_88 VGND VGND VPWR VPWR sky130_fd_sc_hd__fill_2
XTAP_TAPCELL_ROW_4_56 VGND VPWR sky130_fd_sc_hd__tapvpwrvgnd_1
XPHY_EDGE_ROW_17_Right_17 VGND VGND VPWR VPWR sky130_fd_sc_hd__decap_3
XFILLER_14_76 VGND VGND VPWR VPWR sky130_fd_sc_hd__decap_3
XTAP_TAPCELL_ROW_14_76 VGND VPWR sky130_fd_sc_hd__tapvpwrvgnd_1
XFILLER_2_24 VGND VGND VPWR VPWR sky130_fd_sc_hd__decap_3
XFILLER_11_55 VGND VGND VPWR VPWR sky130_fd_sc_hd__fill_1
XFILLER_14_111 VGND VGND VPWR VPWR sky130_fd_sc_hd__decap_3
Xinput16 tx_data[22] VGND VGND VPWR VPWR _082_/A1 sky130_fd_sc_hd__clkdlybuf4s25_1
Xinput27 tx_data[3] VGND VGND VPWR VPWR _063_/A1 sky130_fd_sc_hd__clkdlybuf4s25_1
XFILLER_22_32 VGND VGND VPWR VPWR sky130_fd_sc_hd__fill_1
XFILLER_17_87 VGND VGND VPWR VPWR sky130_fd_sc_hd__fill_1
XTAP_TAPCELL_ROW_4_57 VGND VPWR sky130_fd_sc_hd__tapvpwrvgnd_1
XFILLER_0_102 VGND VGND VPWR VPWR sky130_fd_sc_hd__fill_2
XFILLER_5_57 VGND VGND VPWR VPWR sky130_fd_sc_hd__fill_2
XTAP_TAPCELL_ROW_14_77 VGND VPWR sky130_fd_sc_hd__tapvpwrvgnd_1
XFILLER_14_88 VGND VGND VPWR VPWR sky130_fd_sc_hd__fill_2
XFILLER_17_131 VGND VGND VPWR VPWR sky130_fd_sc_hd__decap_3
XFILLER_11_89 VGND VGND VPWR VPWR sky130_fd_sc_hd__decap_3
XFILLER_14_123 VGND VGND VPWR VPWR sky130_fd_sc_hd__fill_1
Xinput17 tx_data[23] VGND VGND VPWR VPWR _083_/A1 sky130_fd_sc_hd__clkdlybuf4s25_1
Xinput28 tx_data[4] VGND VGND VPWR VPWR _064_/A1 sky130_fd_sc_hd__clkdlybuf4s25_1
X_089_ _089_/A0 _089_/A1 _089_/S VGND VGND VPWR VPWR _138_/D sky130_fd_sc_hd__mux2_1
XFILLER_17_44 VGND VGND VPWR VPWR sky130_fd_sc_hd__decap_3
XFILLER_3_111 VGND VGND VPWR VPWR sky130_fd_sc_hd__fill_1
XPHY_EDGE_ROW_3_Right_3 VGND VGND VPWR VPWR sky130_fd_sc_hd__decap_3
XFILLER_5_47 VGND VGND VPWR VPWR sky130_fd_sc_hd__fill_1
XFILLER_14_67 VGND VGND VPWR VPWR sky130_fd_sc_hd__decap_3
XFILLER_11_46 VGND VGND VPWR VPWR sky130_fd_sc_hd__fill_1
XFILLER_11_57 VGND VGND VPWR VPWR sky130_fd_sc_hd__fill_2
Xinput18 tx_data[24] VGND VGND VPWR VPWR _084_/A1 sky130_fd_sc_hd__clkdlybuf4s25_1
Xinput29 tx_data[5] VGND VGND VPWR VPWR _065_/A1 sky130_fd_sc_hd__clkdlybuf4s25_1
XFILLER_20_127 VGND VGND VPWR VPWR sky130_fd_sc_hd__decap_3
XFILLER_11_116 VGND VGND VPWR VPWR sky130_fd_sc_hd__fill_2
XFILLER_19_3 VGND VGND VPWR VPWR sky130_fd_sc_hd__decap_3
X_088_ hold97/X _088_/A1 _088_/S VGND VGND VPWR VPWR _137_/D sky130_fd_sc_hd__mux2_1
XFILLER_8_14 VGND VGND VPWR VPWR sky130_fd_sc_hd__decap_3
XFILLER_17_78 VGND VGND VPWR VPWR sky130_fd_sc_hd__decap_3
XPHY_EDGE_ROW_13_Left_36 VGND VGND VPWR VPWR sky130_fd_sc_hd__decap_3
XPHY_EDGE_ROW_22_Right_22 VGND VGND VPWR VPWR sky130_fd_sc_hd__decap_3
XPHY_EDGE_ROW_13_Right_13 VGND VGND VPWR VPWR sky130_fd_sc_hd__decap_3
XFILLER_14_79 VGND VGND VPWR VPWR sky130_fd_sc_hd__decap_3
XFILLER_6_80 VGND VGND VPWR VPWR sky130_fd_sc_hd__decap_3
XFILLER_2_27 VGND VGND VPWR VPWR sky130_fd_sc_hd__fill_1
XFILLER_14_114 VGND VGND VPWR VPWR sky130_fd_sc_hd__fill_1
Xinput19 tx_data[25] VGND VGND VPWR VPWR _085_/A1 sky130_fd_sc_hd__clkdlybuf4s25_1
XPHY_EDGE_ROW_1_Left_24 VGND VGND VPWR VPWR sky130_fd_sc_hd__decap_3
XFILLER_22_57 VGND VGND VPWR VPWR sky130_fd_sc_hd__decap_3
X_087_ _087_/A0 _087_/A1 _089_/S VGND VGND VPWR VPWR _136_/D sky130_fd_sc_hd__mux2_1
X_139_ _139_/CLK _139_/D fanout77/X VGND VGND VPWR VPWR _139_/Q sky130_fd_sc_hd__dfrtp_2
XFILLER_14_58 VGND VGND VPWR VPWR sky130_fd_sc_hd__decap_3
XFILLER_9_3 VGND VGND VPWR VPWR sky130_fd_sc_hd__decap_3
XFILLER_15_90 VGND VGND VPWR VPWR sky130_fd_sc_hd__decap_3
XFILLER_12_91 VGND VGND VPWR VPWR sky130_fd_sc_hd__fill_2
X_086_ hold98/X _086_/A1 _089_/S VGND VGND VPWR VPWR _135_/D sky130_fd_sc_hd__mux2_1
XFILLER_8_49 VGND VGND VPWR VPWR sky130_fd_sc_hd__decap_3
XFILLER_8_38 VGND VGND VPWR VPWR sky130_fd_sc_hd__decap_3
XFILLER_8_27 VGND VGND VPWR VPWR sky130_fd_sc_hd__fill_1
XFILLER_17_47 VGND VGND VPWR VPWR sky130_fd_sc_hd__fill_1
X_138_ _138_/CLK _138_/D fanout80/X VGND VGND VPWR VPWR _138_/Q sky130_fd_sc_hd__dfrtp_2
X_069_ hold99/X _069_/A1 _090_/S VGND VGND VPWR VPWR _118_/D sky130_fd_sc_hd__mux2_1
XFILLER_9_81 VGND VGND VPWR VPWR sky130_fd_sc_hd__decap_3
XPHY_EDGE_ROW_7_Right_7 VGND VGND VPWR VPWR sky130_fd_sc_hd__decap_3
XFILLER_6_93 VGND VGND VPWR VPWR sky130_fd_sc_hd__decap_3
XFILLER_17_113 VGND VGND VPWR VPWR sky130_fd_sc_hd__decap_3
XFILLER_2_29 VGND VGND VPWR VPWR sky130_fd_sc_hd__decap_3
XFILLER_11_16 VGND VGND VPWR VPWR sky130_fd_sc_hd__decap_3
XFILLER_8_17 VGND VGND VPWR VPWR sky130_fd_sc_hd__fill_2
X_085_ _085_/A0 _085_/A1 _088_/S VGND VGND VPWR VPWR _134_/D sky130_fd_sc_hd__mux2_1
XFILLER_17_26 VGND VGND VPWR VPWR sky130_fd_sc_hd__fill_2
X_137_ _139_/CLK _137_/D fanout73/X VGND VGND VPWR VPWR _137_/Q sky130_fd_sc_hd__dfrtp_2
X_068_ hold95/X _068_/A1 _090_/S VGND VGND VPWR VPWR _117_/D sky130_fd_sc_hd__mux2_1
XFILLER_0_129 VGND VGND VPWR VPWR sky130_fd_sc_hd__decap_3
XFILLER_17_3 VGND VGND VPWR VPWR sky130_fd_sc_hd__decap_3
Xclkbuf_3_5__f_clk clkbuf_0_clk/X VGND VGND VPWR VPWR _138_/CLK sky130_fd_sc_hd__clkbuf_16
XFILLER_14_27 VGND VGND VPWR VPWR sky130_fd_sc_hd__fill_1
Xhold90 _114_/Q VGND VGND VPWR VPWR hold90/X sky130_fd_sc_hd__dlygate4sd3_1
XFILLER_6_83 VGND VGND VPWR VPWR sky130_fd_sc_hd__fill_1
XFILLER_6_50 VGND VGND VPWR VPWR sky130_fd_sc_hd__fill_1
XFILLER_15_81 VGND VGND VPWR VPWR sky130_fd_sc_hd__decap_3
XFILLER_22_27 VGND VGND VPWR VPWR sky130_fd_sc_hd__fill_1
XPHY_EDGE_ROW_5_Left_28 VGND VGND VPWR VPWR sky130_fd_sc_hd__decap_3
XFILLER_12_82 VGND VGND VPWR VPWR sky130_fd_sc_hd__fill_2
X_084_ _084_/A0 _084_/A1 _089_/S VGND VGND VPWR VPWR _133_/D sky130_fd_sc_hd__mux2_1
X_136_ _145_/CLK _136_/D fanout79/X VGND VGND VPWR VPWR _136_/Q sky130_fd_sc_hd__dfrtp_2
X_067_ _067_/A0 _067_/A1 _090_/S VGND VGND VPWR VPWR _116_/D sky130_fd_sc_hd__mux2_1
XPHY_EDGE_ROW_8_Left_31 VGND VGND VPWR VPWR sky130_fd_sc_hd__decap_3
X_119_ _140_/CLK _119_/D load_slew74/X VGND VGND VPWR VPWR _119_/Q sky130_fd_sc_hd__dfrtp_2
XFILLER_20_82 VGND VGND VPWR VPWR sky130_fd_sc_hd__fill_2
Xhold91 _122_/Q VGND VGND VPWR VPWR hold91/X sky130_fd_sc_hd__dlygate4sd3_1
XFILLER_15_60 VGND VGND VPWR VPWR sky130_fd_sc_hd__decap_3
XFILLER_15_93 VGND VGND VPWR VPWR sky130_fd_sc_hd__decap_3
XFILLER_9_6 VGND VGND VPWR VPWR sky130_fd_sc_hd__fill_1
XTAP_TAPCELL_ROW_2_52 VGND VPWR sky130_fd_sc_hd__tapvpwrvgnd_1
XFILLER_7_3 VGND VGND VPWR VPWR sky130_fd_sc_hd__decap_3
XPHY_EDGE_ROW_21_Left_44 VGND VGND VPWR VPWR sky130_fd_sc_hd__decap_3
XTAP_TAPCELL_ROW_12_72 VGND VPWR sky130_fd_sc_hd__tapvpwrvgnd_1
X_083_ hold87/X _083_/A1 _088_/S VGND VGND VPWR VPWR _132_/D sky130_fd_sc_hd__mux2_1
X_135_ _138_/CLK _135_/D load_slew76/X VGND VGND VPWR VPWR _135_/Q sky130_fd_sc_hd__dfrtp_2
X_066_ _066_/A0 _066_/A1 _088_/S VGND VGND VPWR VPWR _115_/D sky130_fd_sc_hd__mux2_1
XFILLER_9_84 VGND VGND VPWR VPWR sky130_fd_sc_hd__fill_2
XFILLER_18_82 VGND VGND VPWR VPWR sky130_fd_sc_hd__fill_2
X_118_ _125_/CLK _118_/D _058_/B VGND VGND VPWR VPWR _118_/Q sky130_fd_sc_hd__dfrtp_2
Xhold81 _141_/Q VGND VGND VPWR VPWR hold81/X sky130_fd_sc_hd__dlygate4sd3_1
Xhold92 _128_/Q VGND VGND VPWR VPWR hold92/X sky130_fd_sc_hd__dlygate4sd3_1
XFILLER_17_116 VGND VGND VPWR VPWR sky130_fd_sc_hd__decap_3
XFILLER_15_72 VGND VGND VPWR VPWR sky130_fd_sc_hd__decap_3
Xoutput60 _112_/Q VGND VGND VPWR VPWR rx_data[3] sky130_fd_sc_hd__clkdlybuf4s25_1
XTAP_TAPCELL_ROW_2_53 VGND VPWR sky130_fd_sc_hd__tapvpwrvgnd_1
XFILLER_22_29 VGND VGND VPWR VPWR sky130_fd_sc_hd__decap_3
X_082_ hold85/X _082_/A1 _088_/S VGND VGND VPWR VPWR _131_/D sky130_fd_sc_hd__mux2_1
XTAP_TAPCELL_ROW_12_73 VGND VPWR sky130_fd_sc_hd__tapvpwrvgnd_1
XFILLER_0_54 VGND VGND VPWR VPWR sky130_fd_sc_hd__fill_2
XFILLER_17_6 VGND VGND VPWR VPWR sky130_fd_sc_hd__decap_3
X_134_ _134_/CLK _134_/D load_slew74/X VGND VGND VPWR VPWR _134_/Q sky130_fd_sc_hd__dfrtp_2
X_065_ hold90/X _065_/A1 _146_/D VGND VGND VPWR VPWR _114_/D sky130_fd_sc_hd__mux2_1
X_117_ _146_/CLK _117_/D fanout77/X VGND VGND VPWR VPWR _117_/Q sky130_fd_sc_hd__dfrtp_2
XFILLER_15_3 VGND VGND VPWR VPWR sky130_fd_sc_hd__decap_3
Xhold82 _129_/Q VGND VGND VPWR VPWR hold82/X sky130_fd_sc_hd__dlygate4sd3_1
Xhold93 _139_/Q VGND VGND VPWR VPWR hold93/X sky130_fd_sc_hd__dlygate4sd3_1
XFILLER_15_84 VGND VGND VPWR VPWR sky130_fd_sc_hd__decap_3
XFILLER_17_128 VGND VGND VPWR VPWR sky130_fd_sc_hd__decap_3
Xoutput50 _132_/Q VGND VGND VPWR VPWR rx_data[23] sky130_fd_sc_hd__clkdlybuf4s25_1
Xoutput61 _113_/Q VGND VGND VPWR VPWR rx_data[4] sky130_fd_sc_hd__clkdlybuf4s25_1
XFILLER_9_113 VGND VGND VPWR VPWR sky130_fd_sc_hd__decap_3
X_081_ _081_/A0 _081_/A1 _146_/D VGND VGND VPWR VPWR _130_/D sky130_fd_sc_hd__mux2_1
XTAP_TAPCELL_ROW_8_64 VGND VPWR sky130_fd_sc_hd__tapvpwrvgnd_1
XPHY_EDGE_ROW_16_Right_16 VGND VGND VPWR VPWR sky130_fd_sc_hd__decap_3
XFILLER_0_11 VGND VGND VPWR VPWR sky130_fd_sc_hd__fill_1
X_133_ _133_/CLK _133_/D fanout75/X VGND VGND VPWR VPWR _133_/Q sky130_fd_sc_hd__dfrtp_2
X_064_ hold84/X _064_/A1 _146_/D VGND VGND VPWR VPWR _113_/D sky130_fd_sc_hd__mux2_1
Xclkbuf_3_0__f_clk clkbuf_0_clk/X VGND VGND VPWR VPWR _140_/CLK sky130_fd_sc_hd__clkbuf_16
XTAP_TAPCELL_ROW_18_84 VGND VPWR sky130_fd_sc_hd__tapvpwrvgnd_1
X_116_ _139_/CLK _116_/D fanout77/X VGND VGND VPWR VPWR _116_/Q sky130_fd_sc_hd__dfrtp_2
XPHY_EDGE_ROW_2_Right_2 VGND VGND VPWR VPWR sky130_fd_sc_hd__decap_3
Xhold83 _140_/Q VGND VGND VPWR VPWR hold83/X sky130_fd_sc_hd__dlygate4sd3_1
Xhold94 _124_/Q VGND VGND VPWR VPWR hold94/X sky130_fd_sc_hd__dlygate4sd3_1
XFILLER_6_32 VGND VGND VPWR VPWR sky130_fd_sc_hd__fill_1
XFILLER_15_63 VGND VGND VPWR VPWR sky130_fd_sc_hd__decap_3
Xoutput40 _123_/Q VGND VGND VPWR VPWR rx_data[14] sky130_fd_sc_hd__clkdlybuf4s25_1
Xoutput51 _133_/Q VGND VGND VPWR VPWR rx_data[24] sky130_fd_sc_hd__clkdlybuf4s25_1
Xoutput62 _114_/Q VGND VGND VPWR VPWR rx_data[5] sky130_fd_sc_hd__clkdlybuf4s25_1
XFILLER_7_6 VGND VGND VPWR VPWR sky130_fd_sc_hd__fill_1
X_080_ hold82/X _080_/A1 _090_/S VGND VGND VPWR VPWR _129_/D sky130_fd_sc_hd__mux2_1
XFILLER_6_117 VGND VGND VPWR VPWR sky130_fd_sc_hd__fill_1
XTAP_TAPCELL_ROW_8_65 VGND VPWR sky130_fd_sc_hd__tapvpwrvgnd_1
X_132_ _140_/CLK _132_/D load_slew74/X VGND VGND VPWR VPWR _132_/Q sky130_fd_sc_hd__dfrtp_2
X_063_ _063_/A0 _063_/A1 _088_/S VGND VGND VPWR VPWR _112_/D sky130_fd_sc_hd__mux2_1
XFILLER_18_85 VGND VGND VPWR VPWR sky130_fd_sc_hd__decap_3
XTAP_TAPCELL_ROW_18_85 VGND VPWR sky130_fd_sc_hd__tapvpwrvgnd_1
X_115_ _134_/CLK _115_/D load_slew74/X VGND VGND VPWR VPWR _115_/Q sky130_fd_sc_hd__dfrtp_2
XPHY_EDGE_ROW_12_Left_35 VGND VGND VPWR VPWR sky130_fd_sc_hd__decap_3
Xhold84 _113_/Q VGND VGND VPWR VPWR hold84/X sky130_fd_sc_hd__dlygate4sd3_1
Xhold95 _117_/Q VGND VGND VPWR VPWR hold95/X sky130_fd_sc_hd__dlygate4sd3_1
XFILLER_20_3 VGND VGND VPWR VPWR sky130_fd_sc_hd__decap_3
XFILLER_15_75 VGND VGND VPWR VPWR sky130_fd_sc_hd__decap_3
Xoutput41 _124_/Q VGND VGND VPWR VPWR rx_data[15] sky130_fd_sc_hd__clkdlybuf4s25_1
Xoutput52 _134_/Q VGND VGND VPWR VPWR rx_data[25] sky130_fd_sc_hd__clkdlybuf4s25_1
Xoutput63 _115_/Q VGND VGND VPWR VPWR rx_data[6] sky130_fd_sc_hd__clkdlybuf4s25_1
.ends
